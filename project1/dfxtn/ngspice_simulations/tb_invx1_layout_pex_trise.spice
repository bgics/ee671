.lib $PDK_ROOT/sky130A/libs.tech/ngspice/sky130.lib.spice tt

.include invx1_layout_pex.spice

VDD vdd 0 DC 1.8
VSS vss 0 DC 0

.param d_half_slew = 500p
.param d_rise_point1 = 5n
.param d_rise_point2 = 15n

VD a 0 PWL(0n 1.8 {d_rise_point1 - d_half_slew} 1.8 {d_rise_point1 + d_half_slew} 0 {d_rise_point2 - d_half_slew} 0 {d_rise_point2 + d_half_slew} 1.8)

XDF1 a y vdd vss invx1
CLOAD y vss 100f

.tran 10p 20n

.meas tran q_fall TRIG V(y) VAL=1.44 FALL=1 TARG V(y) VAL=0.36 FALL=1 TD=2n
.meas tran q_rise TRIG V(y) VAL=0.36 RISE=1 TARG V(y) VAL=1.44 RISE=1 TD=2n

.meas tran tp_rise TRIG V(a) VAL=0.9 FALL=1 TARG V(y) VAL=0.9 RISE=1 TD=2n
.meas tran tp_fall TRIG V(a) VAL=0.9 RISE=1 TARG V(y) VAL=0.9 FALL=1 TD=2n

.control
run

set color0 = white
set color1 = black
set color2 = red

* plot V(a) V(y)
.endc

.end

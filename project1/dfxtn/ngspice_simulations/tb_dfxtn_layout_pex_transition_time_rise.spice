.lib $PDK_ROOT/sky130A/libs.tech/ngspice/sky130.lib.spice tt

.include dfxtn_schematic.spice

VDD vdd 0 DC 1.8
VSS vss 0 DC 0

.param clk_half_slew = 5p
.param d_half_slew = 500p
.param d_rise_point = 9.5n

VCLK clk 0 PWL(0n 1.8 {10n - clk_half_slew} 1.8 {10n + clk_half_slew} 0)
VD d 0 PWL(0n 0 {d_rise_point - d_half_slew} 0 {d_rise_point + d_half_slew} 1.8)

XDF1 d q clk vdd vss dfxtn
CLOAD q vss 100f

.ic V(q) = 1.8
.tran 10p 20n

.meas tran q_rise TRIG V(q) VAL=0.36 RISE=1 TARG V(q) VAL=1.44 RISE=1 TD=2n

.control
run

set color0 = white
set color1 = black
set color2 = red

plot V(clk) V(d)
plot V(q)
.endc

.end

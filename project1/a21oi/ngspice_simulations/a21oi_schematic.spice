.subckt a21oi a1 a2 b1 vdd vss y

xpm_a1 na a1 vdd vdd sky130_fd_pr__pfet_01v8 l=0.15 w=3 as=0.9 ad=0.9 ps=6.6 pd=6.6
xpm_a2 na a2 vdd vdd sky130_fd_pr__pfet_01v8 l=0.15 w=3 as=0.9 ad=0.9 ps=6.6 pd=6.6
xpm_b1 y b1 na vdd sky130_fd_pr__pfet_01v8 l=0.15 w=3 as=0.9 ad=0.9 ps=6.6 pd=6.6

xnm_a1 y a1 nb vss sky130_fd_pr__nfet_01v8 l=0.15 w=0.9 as=0.27 ad=0.27 ps=2.4 pd=2.4
xnm_a2 nb a2 vss vss sky130_fd_pr__nfet_01v8 l=0.15 w=0.9 as=0.27 ad=0.27 ps=2.4 pd=2.4
xnm_b1 y b1 vss vss sky130_fd_pr__nfet_01v8 l=0.15 w=0.45 as=0.135 ad=0.135 ps=1.5 pd=1.5

.ends

.lib $PDK_ROOT/sky130A/libs.tech/ngspice/sky130.lib.spice tt

.include a21oi_schematic.spice

VDD vdd 0 DC 1.8
VSS vss 0 DC 0

VA a 0 PWL(0n 0 4n 0 4.02n 1.8 8n 1.8 8.02n 0 12n 0 12.02n 1.8 16n 1.8 16.02n 0)
* VB b 0 PWL(0n 0 8n 0 8.02n 1.8 16n 1.8 16.02n 0)

VA1 a1 0 PWL(0n 0)
VA2 a2 0 PWL(0n 0 4n 0 4.02n 1.8 8n 1.8 8.02n 0 12n 0 12.02n 1.8 16n 1.8 16.02n 0)
VB1 b1 0 PWL(0n 0 8n 0 8.02n 1.8 16n 1.8 16.02n 0)

XNOR a1 a2 b1 y vdd vss a21oi
XLOAD y nc vdd vss invx1_sch

.tran 10p 20n

.meas tran q_rise TRIG V(y) VAL=0.36 RISE=1 TARG V(y) VAL=1.44 RISE=1
.meas tran q_fall TRIG V(y) VAL=1.44 FALL=1 TARG V(y) VAL=0.36 FALL=1

.control
run
plot V(a1)
plot V(a2)
plot V(b1)
plot V(y)
.endc

.end

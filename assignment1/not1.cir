.subckt not1 vin vout vdd vss
xmp vout vin vdd vdd sky130_fd_pr__pfet_01v8 l=0.15 w=1.26043 as=0.378129 ad=0.378129 ps=3.12086 pd=3.12086
xmn vout vin vss vss sky130_fd_pr__nfet_01v8 l=0.15 w=0.42 as=0.126 ad=0.126 ps=1.44 pd=1.44
.ends
